* Fast Corner - Aggressive conditions
* Process: Fast transistors
* Voltage: High supply
* Temperature: Low (devices faster at low temp)

* Corner parameters override template values
.param VDD=1.3
.param TEMP=-10

* Process parameters (if supported by models)
* .param NMOS_VTH_SHIFT=-0.05
* .param PMOS_VTH_SHIFT=0.05
* Fast Corner - Aggressive conditions
* Process: Fast transistors
* Voltage: High supply
* Temperature: Low (devices faster at low temp)

* Corner parameters override template values
.param VDD=1.3
.param TEMP=-10

* Process parameters (if supported by models)
* .param NMOS_VTH_SHIFT=-0.05
* .param PMOS_VTH_SHIFT=0.05
