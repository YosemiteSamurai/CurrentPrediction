* Slow Corner - Conservative conditions
* Process: Slow transistors
* Voltage: Low supply
* Temperature: High (devices slower at high temp)

* Corner parameters override template values
.param VDD=0.9
.param TEMP=85

* Process parameters (if supported by models)
* .param NMOS_VTH_SHIFT=0.05
* .param PMOS_VTH_SHIFT=-0.05
