* Cold Corner - Low temperature operation
* Process: Typical
* Voltage: Nominal
* Temperature: Low temperature

.param TEMP=-20
* .param VDD=1.2   ; commented out to allow parameterized VDD
.param TEMP=-20

* Low temperature corner for arctic/space applications
