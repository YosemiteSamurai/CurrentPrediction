* Typical Corner - Nominal conditions
* Process: Typical
* Voltage: Nominal
* Temperature: Room temperature

.param TEMP=25
* .param VDD=1.2   ; commented out to allow parameterized VDD
.param TEMP=25

* No process variation parameters for typical corner
* Typical Corner - Nominal conditions
* Process: Typical
* Voltage: Nominal
* Temperature: Room temperature

.param TEMP=25
* .param VDD=1.2   ; commented out to allow parameterized VDD
.param TEMP=25

* No process variation parameters for typical corner
