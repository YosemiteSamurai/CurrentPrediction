* Hot Corner - High temperature operation
* Process: Typical
* Voltage: Nominal
* Temperature: High temperature stress

.param TEMP=125
* .param VDD=1.2   ; commented out to allow parameterized VDD
.param TEMP=125

* High temperature corner for reliability analysis
